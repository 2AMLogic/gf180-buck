** sch_path: /home/ubuntu/GitHub/gf180-buck/.loom/worktrees/issue-33/design/schematics/power_stage.sch
.subckt power_stage GH GL VIN SW GND
*.ipin GH
*.ipin GL
*.iopin VIN
*.iopin SW
*.iopin GND
XMHS SW GH VIN VIN pfet_06v0 L=0.55u W=100u nf=10 ad='int((nf+1)/2) * W/nf * 0.18u' as='int((nf+2)/2) * W/nf * 0.18u'
+ pd='2*int((nf+1)/2) * (W/nf + 0.18u)' ps='2*int((nf+2)/2) * (W/nf + 0.18u)' nrd='0.18u / W' nrs='0.18u / W'
+ sa=0 sb=0 sd=0 m=300
XMLS SW GL GND GND nfet_06v0 L=0.7u W=100u nf=10 ad='int((nf+1)/2) * W/nf * 0.18u' as='int((nf+2)/2) * W/nf * 0.18u'
+ pd='2*int((nf+1)/2) * (W/nf + 0.18u)' ps='2*int((nf+2)/2) * (W/nf + 0.18u)' nrd='0.18u / W' nrs='0.18u / W'
+ sa=0 sb=0 sd=0 m=224
.ends
