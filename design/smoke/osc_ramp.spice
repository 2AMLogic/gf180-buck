* osc_ramp smoke: typical corner, 27 C, VDD33 3.3 V, IBIAS 12 uA, TRIM=101b. SIMULATED.
.include @DESIGN_INC@
.lib @MODEL_FILE@ typical
.lib @MODEL_FILE@ mimcap_typical
.lib @MODEL_FILE@ cap_mim
.lib @MODEL_FILE@ res_typical
.include @NETLIST_DIR@/osc_ramp.spice
Vdd vdd33 0 3.3
Ib 0 ibias 12u
Vt0 tr0 0 3.3
Vt1 tr1 0 0
Vt2 tr2 0 3.3
Xdut ibias tr0 tr1 tr2 clk ramp vdd33 0 osc_ramp
.control
tran 1n 40u
meas tran tper20 TRIG v(clk) VAL=1.65 RISE=30 TARG v(clk) VAL=1.65 RISE=50
meas tran vhi MAX v(ramp) FROM=20u TO=40u
meas tran vlo MIN v(ramp) FROM=20u TO=40u
meas tran idd AVG i(Vdd) FROM=20u TO=40u
let f_mhz = 20/tper20*1e-6
echo "RESULT osc f_MHz= $&f_mhz"
quit
.endc
.end
