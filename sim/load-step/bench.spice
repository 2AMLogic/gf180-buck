* gf180-buck load-step bench (issue #59; spec R12, R13(b)): the shared bench harness
* (sim/lib/bench_harness.spice) with a 50 -> 450 -> 50 mA step pair at 1 A/us as the load.
* Body for `klt sim` (no .control).
* Request axes: process, Vin (source Vsrc), temperature and the P-T tolerances lfac / c_out / esr (spec 0.2);
* everything else is fixed here. collect.py reads t_up / t_dn / i_lo / i_hi / t_edge from the .param line below.
* and the load are request axes; everything else is fixed here and stated in README.md.
* --- inlined from gf180mcuD/libs.tech/ngspice/design.ngspice (sha256 091cb530bf85160a1f07878fb81f789ca367d018991c8ab41a584cd1a85c6692) ---
.param
+  sw_stat_global = 0
+  sw_stat_mismatch = 0
+ mc_skew = 3
+ res_mc_skew = 3
+ cap_mc_skew = 3
+  fnoicor = 0
* --- end inline ---
.options gmin=1e-13
.include ../../design/netlists/buck_top.spice
.include ../steady-state/opamp_two_stage.spice

* ---- request axes (klt corners.params overrides these defaults) ----
.param lfac=1 vdd3=3.3 vbg=1.2
* ---- fixed bench assumptions ----
.param l_ind={3.3u*lfac} dcr=0.1 c_wind=3p r_wind=20
.param c_out=6u esr=5m esl=0.5n
.param r_wire=0.10 l_wire=2n wires=2
.param c_die=1u esr_die=20m
.param osc_k=1
.param t_en=20u t_load=260u t_load_ramp=0.5u
* Load step (spec R12): 0.4 A at 1 A/us = 0.4 us edge. Applied only after the 0.4 settled test passes (graded in collect.py).
.param i_lo=0.05 i_hi=0.45 t_up=600u t_dn=680u t_edge=0.4u

* Board side: ideal source (Vin), ramped from 0; klt rescales this PWL per corner
Vsrc vsrc 0 PWL(0 0 10u 5)
* ---- shared bench harness: package, control domain, buck_top, external L and C ----
* Kept once in sim/lib/bench_harness.spice (issue #151) and included by every closed-loop
* bench; Vsrc above and the load card below stay here, in the top-level deck.
.include ../lib/bench_harness.spice
* Load: ideal current sink, 0 until soft start is done, then i_lo, then the step pair
Iload out gnd_d PWL(0 0 {t_load} 0 {t_load+t_load_ramp} {i_lo} {t_up} {i_lo} {t_up+t_edge} {i_hi} {t_dn} {i_hi} {t_dn+t_edge} {i_lo})
