* ISSUE #77 PROBE 4 (R15 start-up, 3.6 ohm resistive load from t=0) = bench_ss77.spice with Iload replaced by Rload. Probe only.
* ISSUE #82 PROBE (EA stand-in) = bench_kelvin82.spice with opamp_two_stage replaced by ../steady-state/probe82/opamp_gbw.spice. Previous header:
* ISSUE #82 PROBE VARIANT of bench.spice: power ground (gnd_p) split from control ground (gnd_d);
* control ground has its own single wire to board 0 (kelvin), Cout/ESL/Iload return to board 0.
* gf180-buck steady-state bench (issue #57): the real buck_top, closed loop, with the
* external P-T parts (spec 0.2) and the 0.3 typical package at 2 wires per net.
* Body for `klt sim` (no .control). Corner axes (process, Vin = source Vsrc, temperature)
* and the load are request axes; everything else is fixed here and stated in README.md.
* --- inlined from gf180mcuD/libs.tech/ngspice/design.ngspice (sha256 091cb530bf85160a1f07878fb81f789ca367d018991c8ab41a584cd1a85c6692) ---
.param
+  sw_stat_global = 0
+  sw_stat_mismatch = 0
+ mc_skew = 3
+ res_mc_skew = 3
+ cap_mc_skew = 3
+  fnoicor = 0
* --- end inline ---
.options gmin=1e-13
.include ../steady-state/probe82/buck_top_kelvin.spice
.include ../steady-state/probe82/opamp_gbw.spice

* ---- request axes (klt corners.params overrides these defaults) ----
.param rload=3.6 lfac=1 vdd3=3.3 vbg=1.2
* ---- fixed bench assumptions ----
.param l_ind={3.3u*lfac} dcr=0.1 c_wind=3p r_wind=20
.param c_out=6u esr=5m esl=0.5n
.param r_wire=0.10 l_wire=2n wires=2
.param c_die=1u esr_die=20m
.param t_en=20u t_load=260u t_load_ramp=0.5u

* Board side: ideal source (Vin), ramped from 0; klt rescales this PWL per corner
Vsrc vsrc 0 PWL(0 0 10u 5)
* Package: VIN / SW / GND nets, N parallel wires each. 0.5 pF pad capacitance omitted
* (same reason as sim/buck-ideal/buck.spice); die-side Vin decoupling is a bench assumption.
Rwv vsrc nv1 {r_wire/wires}
Lwv nv1 vin_d {l_wire/wires}
Rws sw_d nsw1 {r_wire/wires}
Lws nsw1 sw_p {l_wire/wires}
Rwg gnd_p ng1 {r_wire/wires}
Lwg ng1 0 {l_wire/wires}
Rwc gnd_d nc1 {r_wire}
Lwc nc1 0 {l_wire}
Cdie vin_d nd1 {c_die}
Rdie nd1 gnd_p {esr_die}

* Control-domain ports (no bandgap / regulator / bias block in this design yet: ideal
* sources, fixed over corners; see README.md "Bench assumptions"). All up before EN.
Vdd33 vdd33 gnd_d PWL(0 0 5u {vdd3})
Vbg vbg gnd_d PWL(0 0 5u {vbg})
Iosc gnd_d ib_osc PWL(0 0 5u 12u)
Ipwm gnd_d ib_pwm PWL(0 0 5u 10u)
Iss gnd_d ib_ss PWL(0 0 5u 10u)
Iocp gnd_d ib_ocp PWL(0 0 5u 10u)
Iea gnd_d ib_ea PWL(0 0 5u 10u)
Vt0 tr0 gnd_d {vdd3}
Vt1 tr1 gnd_d 0
Vt2 tr2 gnd_d {vdd3}
Ven en gnd_d PWL(0 0 {t_en} 0 {t_en+10n} {vdd3})

Xtop vin_d vdd33 gnd_d sw_d out en vbg ib_osc ib_pwm ib_ss ib_ocp ib_ea tr0 tr1 tr2 vc pwm vref_ss gnd_p buck_top

* External inductor L + DCR, parallel winding capacitance (r_wind in series, as in buck-ideal)
Lind sw_p nl {l_ind}
Rdcr nl out {dcr}
Cwind sw_p nw {c_wind}
Rwind nw out {r_wind}
* External capacitor C + ESR + ESL; `out` is the capacitor terminal
Cout out nc {c_out}
Resr nc nd {esr}
Lesl nd 0 {esl}
* Load: 3.6 ohm resistor from t=0 (R15 load case)
Rload out 0 {rload}
