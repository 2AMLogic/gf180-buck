* gf180-buck steady-state bench (issue #57): the real buck_top, closed loop, with the
* external P-T parts (spec 0.2) and the 0.3 typical package at 2 wires per net.
* Body for `klt sim` (no .control). Corner axes (process, Vin = source Vsrc, temperature)
* and the load are request axes; everything else is fixed here and stated in README.md.
* --- inlined from gf180mcuD/libs.tech/ngspice/design.ngspice (sha256 091cb530bf85160a1f07878fb81f789ca367d018991c8ab41a584cd1a85c6692) ---
.param
+  sw_stat_global = 0
+  sw_stat_mismatch = 0
+ mc_skew = 3
+ res_mc_skew = 3
+ cap_mc_skew = 3
+  fnoicor = 0
* --- end inline ---
.options gmin=1e-13
.include ../../design/netlists/buck_top.spice
.include opamp_two_stage.spice

* ---- request axes (klt corners.params overrides these defaults) ----
.param iload=0.25 lfac=1 vdd3=3.3 vbg=1.2
* ---- fixed bench assumptions ----
.param l_ind={3.3u*lfac} dcr=0.1 c_wind=3p r_wind=20
.param c_out=6u esr=5m esl=0.5n
.param r_wire=0.10 l_wire=2n wires=2
.param c_die=1u esr_die=20m
.param osc_k=1
.param t_en=20u t_load=260u t_load_ramp=0.5u

* Board side: ideal source (Vin), ramped from 0; klt rescales this PWL per corner
Vsrc vsrc 0 PWL(0 0 10u 5)
* ---- shared bench harness: package, control domain, buck_top, external L and C ----
* Kept once in sim/lib/bench_harness.spice (issue #151) and included by every closed-loop
* bench; Vsrc above and the load card below stay here, in the top-level deck.
.include ../lib/bench_harness.spice
* Load: ideal current sink, 0 until soft start is done, then iload
Iload out gnd_d PWL(0 0 {t_load} 0 {t_load+t_load_ramp} {iload})
