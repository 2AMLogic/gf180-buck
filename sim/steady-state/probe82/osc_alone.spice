* Issue #82 probe: osc_ramp.spice alone (ideal 12 uA bias as in bench.spice, ideal 3.3 V, ideal 0 V ground),
* typical, 27 C. Reads the ramp valley / peak / period that the averaged model idealises as 0..1.0 V.
* @MODEL_FILE@ / @DESIGN_INC@ are substituted at run time (see sim/smoke/run.sh).
.include @DESIGN_INC@
.lib @MODEL_FILE@ typical
.lib @MODEL_FILE@ mimcap_typical
.lib @MODEL_FILE@ cap_mim
.lib @MODEL_FILE@ res_typical
.options gmin=1e-13
.include design/netlists/osc_ramp.spice
Vdd vdd33 0 PWL(0 0 1u 3.3)
Iosc 0 ib PWL(0 0 1u 12u)
Vt0 tr0 0 3.3
Vt1 tr1 0 0
Vt2 tr2 0 3.3
Xo ib tr0 tr1 tr2 clk ramp vdd33 0 osc_ramp
.control
tran 0.5n 20u 10u 0.5n
meas tran rmax MAX v(ramp) from=10u to=20u
meas tran rmin MIN v(ramp) from=10u to=20u
meas tran rpk2pk PP v(ramp) from=10u to=20u
meas tran t1 WHEN v(clk)=1.65 RISE=10
meas tran t2 WHEN v(clk)=1.65 RISE=20
echo "RESULT osc"
.endc
.end
